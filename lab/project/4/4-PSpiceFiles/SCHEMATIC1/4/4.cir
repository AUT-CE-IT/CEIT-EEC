** Profile: "SCHEMATIC1-4"  [ E:\Courses\AUT\semester 3\Electrical Circuit\lab\project\Orcad\4\4-PSpiceFiles\SCHEMATIC1\4.sim ]

** Creating circuit file "4.cir"
** WARNING: THIS AUTOMATICALLY GENERATED FILE MAY BE OVERWRITTEN BY SUBSEQUENT SIMULATIONS

*Libraries:
* Profile Libraries :
* Local Libraries :
* From [PSPICE NETLIST] section of C:\Users\BARDIA\AppData\Roaming\SPB_Data\cdssetup\OrCAD_PSpice\17.2.0\PSpice.ini file:
.lib "nom.lib"

*Analysis directives:
.TRAN  0 2.5s 0 2ms
.STEP LIN PARAM c 0.03 0.1 0.01
.OPTIONS ADVCONV
.PROBE64 V(alias(*)) I(alias(*)) W(alias(*)) D(alias(*)) NOISE(alias(*))
.INC "..\SCHEMATIC1.net"

.END
